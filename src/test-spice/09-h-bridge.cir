* H-bridge MOSFET motor driver
V1 5 0 12
V2 10 0 PULSE(0 5 0 10n 10n 1u 2u)
V3 11 0 PULSE(5 0 0 10n 10n 1u 2u)
M1 2 10 5 MPMOS
M2 3 11 5 MPMOS
M3 0 11 2 MNMOS
M4 0 10 3 MNMOS
R1 2 3 10
.MODEL MNMOS NMOS(VTO=1.5)
.MODEL MPMOS PMOS(VTO=-1.5)
.END
