* SCR on AC line — 10 Vpk 50 Hz, gate held at 2 V DC via voltage divider.
* Y-element (Sprint 75): Y<name> anode gate cathode
* Expected: positive half triggers latch (current flows through 1 kΩ load),
* negative half extinguishes.
V1 1 0 SIN(0 10 50)
V2 3 0 DC 2
Y1 1 3 2
R1 2 0 1k
.END
