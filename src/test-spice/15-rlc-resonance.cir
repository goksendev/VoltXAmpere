* RLC series resonance — f₀ = 1/(2π√(LC)) ≈ 15.9 kHz
* R=100, L=1m, C=100n → Q = √(L/C)/R = √(10⁴)/100 = 1.0
* At f₀: Vr_peak = Vin × Q. Off-resonance: Vr → 0.
* Vin = 5 V pk, so at resonance Vr_rms ≈ 5/√2 × 1 = 3.54 V RMS across R1.
V1 1 0 SIN(0 5 15900)
R1 1 2 100
L1 2 3 1m
C1 3 0 100n
.END
