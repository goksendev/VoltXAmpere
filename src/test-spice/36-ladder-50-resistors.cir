* Sprint 95: 50-node resistor ladder — pushes the MNA matrix past
* the n>30 threshold where the banded solver takes over from dense,
* so the differential test actually exercises Sp.solveLU_banded.
*
*   V1 -> node 50 through 50 × 1 kΩ resistors in series to ground
*   Final node voltage should be V1 × (0/50) = 0 V at ground side
*   Each tap V(k) = V1 × k / 50  → V(25) = 5 V, V(50) = 10 V
V1 50 0 DC 10
R1  50 49 1k
R2  49 48 1k
R3  48 47 1k
R4  47 46 1k
R5  46 45 1k
R6  45 44 1k
R7  44 43 1k
R8  43 42 1k
R9  42 41 1k
R10 41 40 1k
R11 40 39 1k
R12 39 38 1k
R13 38 37 1k
R14 37 36 1k
R15 36 35 1k
R16 35 34 1k
R17 34 33 1k
R18 33 32 1k
R19 32 31 1k
R20 31 30 1k
R21 30 29 1k
R22 29 28 1k
R23 28 27 1k
R24 27 26 1k
R25 26 25 1k
R26 25 24 1k
R27 24 23 1k
R28 23 22 1k
R29 22 21 1k
R30 21 20 1k
R31 20 19 1k
R32 19 18 1k
R33 18 17 1k
R34 17 16 1k
R35 16 15 1k
R36 15 14 1k
R37 14 13 1k
R38 13 12 1k
R39 12 11 1k
R40 11 10 1k
R41 10 9  1k
R42 9  8  1k
R43 8  7  1k
R44 7  6  1k
R45 6  5  1k
R46 5  4  1k
R47 4  3  1k
R48 3  2  1k
R49 2  1  1k
R50 1  0  1k
.END
