* BJT thermal-safe topology — emitter degeneration + base divider.
* R_E (100 Ω) provides negative feedback as I_C climbs, so the
* thermal-runaway loop can't take hold. Expected T_j steady-state
* well below Tmax with the same solver changes that drive 17-bjt
* into damage.
V1 1 0 DC 15
R1 1 2 470
Q1 2 3 4 Q2N3904
R2 1 3 10k
R3 3 0 3.3k
R4 4 0 100
.END
