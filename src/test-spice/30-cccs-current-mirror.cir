* Sprint 92: CCCS (SPICE F) branch-variable MNA verification
*
* V1 1 0 DC 1 puts +1 V on node 1. R1 pulls 10 mA from node 1 to
* ground, so the current INTO V1's + terminal is negative by
* SPICE convention: I(V1) = −10 mA.
*
* F1 copies that current with gain = 2. I(F1) = −20 mA means the
* CCCS is sourcing (delivering) 20 mA at its + terminal (node 3),
* so node 3 is pulled UP against R2:
*
*   V(3) = +20 mA · 500 Ω = +10 V
V1 1 0 DC 1
R1 1 0 100
F1 3 0 V1 2
R2 3 0 500
.END
