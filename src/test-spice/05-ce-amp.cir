* Common-Emitter BJT Amplifier (DC-biased)
V1 1 0 12
R1 1 2 47k
R2 2 0 10k
RC 1 3 2.2k
RE 4 0 1k
Q1 3 2 4 QMOD
.MODEL QMOD NPN(BF=100)
.END
